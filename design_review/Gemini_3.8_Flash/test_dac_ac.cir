.include ../sim/opamps.lib
Ia 0 va 9.6m
Ib 0 vb 9.6m
Ra va 0 24.9
Rb vb 0 24.9
Rgp va ip 499
Rgn vb im 499
Rtp ip 0 2k
* Ctp ip 0 2.2p
X1 ip im vp5 vm5 out OPA2810
Rf out im 2k
Cf out im 2.2p
Vp5 vp5 0 5
Vm5 vm5 0 -4.4
Rs out sma 49.9
Rload sma 0 50
Cload sma 0 100p

* Check AC response and transient
Vstep step 0 PULSE(0 1m 10n 1n 1n 50n 100n)
B1 0 va_s I=9.6m + v(step)/24.9
B2 0 vb_s I=9.6m - v(step)/24.9

.control
* test with open loop or pulse
tran 0.1n 100n
plot v(out)
meas tran vov max v(out)
print vov
.endc
.end
