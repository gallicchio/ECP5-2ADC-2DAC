Photodiode transimpedance amplifier: 10 k || 2.2 pF, OPA2810; VBPW34S 25 pF typ (40 max) at VR = 3 V (70 pF at 0 V): the rail biases it at 4.2 V
.include opamps.lib
Ipd 0 inn DC 0 AC 1u
Cpd inn 0 25p
X1 0 inn vp5 vm5 out OPA2810
Rf out inn 10k
Cf out inn 2.2p
Vp5 vp5 0 5
Vm5 vm5 0 -4.15
.control
ac dec 20 1k 100meg
let g = db(v(out))
meas ac g1k find g at=1k
meas ac f3db when g=g1k-3 fall=1
meas ac gmax max g
print g1k f3db gmax
.endc
.end
